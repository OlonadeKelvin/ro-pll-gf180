* NGSPICE file created from gf180mcu_fd_sc_mcu7t5v0__dffrnq_1.ext - technology: gf180mcuD

.subckt UN_DFFRNQ_1_GF180mcuD VDD D CLK RN Q VSS VPW VNW
X0 VSS CLK a_36_151# VPW nfet_05v0 ad=0.1053p pd=0.925u as=0.1782p ps=1.69u w=0.405u l=0.6u
X1 VSS RN a_1456_156# VPW nfet_05v0 ad=0.2016p pd=1.48u as=43.2f ps=0.6u w=0.36u l=0.6u
X2 Q a_2665_112# VDD VNW pfet_05v0 ad=0.5346p pd=3.31u as=0.5346p ps=3.31u w=1.215u l=0.5u
X3 a_796_472# D VSS VPW nfet_05v0 ad=93.59999f pd=0.88u as=0.1584p ps=1.6u w=0.36u l=0.6u
X4 VSS a_2665_112# a_2560_156# VPW nfet_05v0 ad=0.1224p pd=1.04u as=94.5f ps=0.885u w=0.36u l=0.6u
X5 a_2665_112# a_2248_156# a_3041_156# VPW nfet_05v0 ad=0.176p pd=1.68u as=0.134p ps=1.1u w=0.4u l=0.6u
X6 a_1000_472# a_448_472# a_796_472# VNW pfet_05v0 ad=0.2028p pd=1.3u as=0.2028p ps=1.3u w=0.78u l=0.5u
X7 a_2248_156# a_36_151# a_1308_423# VNW pfet_05v0 ad=0.25375p pd=1.51u as=0.2424p ps=1.465u w=0.505u l=0.5u
X8 a_2248_156# a_448_472# a_1308_423# VPW nfet_05v0 ad=0.2007p pd=1.475u as=0.2007p ps=1.475u w=0.36u l=0.6u
X9 VDD CLK a_36_151# VNW pfet_05v0 ad=0.2249p pd=1.385u as=0.3806p ps=2.61u w=0.865u l=0.5u
X10 a_1456_156# a_1308_423# a_1288_156# VPW nfet_05v0 ad=43.2f pd=0.6u as=43.2f ps=0.6u w=0.36u l=0.6u
X11 a_1308_423# a_1000_472# VSS VPW nfet_05v0 ad=0.2007p pd=1.475u as=0.2016p ps=1.48u w=0.36u l=0.6u
X12 Q a_2665_112# VSS VPW nfet_05v0 ad=0.3586p pd=2.51u as=0.3586p ps=2.51u w=0.815u l=0.6u
X13 a_448_472# a_36_151# VDD VNW pfet_05v0 ad=0.3806p pd=2.61u as=0.2249p ps=1.385u w=0.865u l=0.5u
X14 a_1204_472# a_36_151# a_1000_472# VNW pfet_05v0 ad=0.2028p pd=1.3u as=0.2028p ps=1.3u w=0.78u l=0.5u
X15 a_1204_472# RN VDD VNW pfet_05v0 ad=0.3432p pd=2.44u as=0.45p ps=2.02u w=0.78u l=0.5u
X16 a_2665_112# RN VDD VNW pfet_05v0 ad=0.26p pd=1.52u as=0.29465p ps=1.74u w=1u l=0.5u
X17 a_2560_156# a_36_151# a_2248_156# VPW nfet_05v0 ad=94.5f pd=0.885u as=0.2007p ps=1.475u w=0.36u l=0.6u
X18 VDD a_2248_156# a_2665_112# VNW pfet_05v0 ad=0.44p pd=2.88u as=0.26p ps=1.52u w=1u l=0.5u
X19 a_1288_156# a_448_472# a_1000_472# VPW nfet_05v0 ad=43.2f pd=0.6u as=93.59999f ps=0.88u w=0.36u l=0.6u
X20 VDD a_1308_423# a_1204_472# VNW pfet_05v0 ad=0.45p pd=2.02u as=0.2028p ps=1.3u w=0.78u l=0.5u
X21 a_2560_156# a_448_472# a_2248_156# VNW pfet_05v0 ad=0.1313p pd=1.025u as=0.25375p ps=1.51u w=0.505u l=0.5u
X22 a_448_472# a_36_151# VSS VPW nfet_05v0 ad=0.1782p pd=1.69u as=0.1053p ps=0.925u w=0.405u l=0.6u
X23 a_3041_156# RN VSS VPW nfet_05v0 ad=0.134p pd=1.1u as=0.1224p ps=1.04u w=0.36u l=0.6u
X24 VDD a_2665_112# a_2560_156# VNW pfet_05v0 ad=0.29465p pd=1.74u as=0.1313p ps=1.025u w=0.505u l=0.5u
X25 a_1308_423# a_1000_472# VDD VNW pfet_05v0 ad=0.2424p pd=1.465u as=0.2222p ps=1.89u w=0.505u l=0.5u
X26 a_1000_472# a_36_151# a_796_472# VPW nfet_05v0 ad=93.59999f pd=0.88u as=93.59999f ps=0.88u w=0.36u l=0.6u
X27 a_796_472# D VDD VNW pfet_05v0 ad=0.2028p pd=1.3u as=0.3432p ps=2.44u w=0.78u l=0.5u
C0 a_1308_423# RN 0.07929f
C1 VSS a_1308_423# 0.01387f
C2 CLK VDD 0.02303f
C3 a_1000_472# a_1308_423# 0.93603f
C4 CLK VNW 0.13704f
C5 a_36_151# a_1308_423# 0.0555f
C6 VNW VDD 0.53049f
C7 a_1204_472# RN 0.02445f
C8 a_2248_156# VDD 1.1204f
C9 VNW a_2248_156# 0.22567f
C10 a_448_472# a_1308_423# 0.88433f
C11 a_1000_472# a_1204_472# 0.66303f
C12 VSS D 0.06462f
C13 D a_796_472# 0.08343f
C14 a_36_151# a_1204_472# 0.01004f
C15 a_1000_472# D 0
C16 a_36_151# D 0.09411f
C17 a_1204_472# a_448_472# 0.00915f
C18 a_2665_112# VDD 0.11288f
C19 a_2665_112# VNW 0.36751f
C20 a_448_472# D 0.32945f
C21 VDD a_2560_156# 0.00217f
C22 a_2665_112# a_2248_156# 0.6371f
C23 VNW a_2560_156# 0.02094f
C24 CLK VSS 0.02195f
C25 a_2248_156# a_2560_156# 0.1207f
C26 VDD Q 0.15085f
C27 a_1204_472# a_1308_423# 0.02892f
C28 VNW Q 0.03444f
C29 VDD RN 0.03498f
C30 VNW RN 0.32949f
C31 a_2665_112# a_3041_156# 0.00226f
C32 VDD VSS 0.01338f
C33 VDD a_796_472# 0
C34 VNW VSS 0.01063f
C35 VNW a_796_472# 0.0124f
C36 a_2248_156# Q 0.01436f
C37 a_2248_156# RN 0.09434f
C38 CLK a_36_151# 0.68095f
C39 a_1000_472# VDD 0.12254f
C40 a_1000_472# VNW 0.24666f
C41 a_2248_156# VSS 0.03047f
C42 a_36_151# VDD 0.41926f
C43 a_36_151# VNW 1.30334f
C44 a_2665_112# a_2560_156# 0.11616f
C45 a_1000_472# a_2248_156# 0.00123f
C46 CLK a_448_472# 0.00276f
C47 a_3041_156# RN 0.01068f
C48 a_36_151# a_2248_156# 0.04526f
C49 VDD a_448_472# 0.45807f
C50 a_2665_112# Q 0.10967f
C51 VNW a_448_472# 0.35246f
C52 a_2665_112# RN 0.33894f
C53 VSS a_1288_156# 0.0017f
C54 a_2665_112# VSS 0.18776f
C55 a_2248_156# a_448_472# 0.51284f
C56 a_1000_472# a_1288_156# 0.00124f
C57 a_2560_156# RN 0.03878f
C58 a_2560_156# VSS 0.1285f
C59 a_2665_112# a_36_151# 0.01904f
C60 VDD a_1308_423# 0.09449f
C61 Q RN 0
C62 VNW a_1308_423# 0.1545f
C63 VSS Q 0.1134f
C64 VSS RN 0.44231f
C65 a_36_151# a_2560_156# 0.00641f
C66 a_448_472# a_1288_156# 0.00207f
C67 VSS a_1456_156# 0.0019f
C68 a_2248_156# a_1308_423# 0.05745f
C69 a_2665_112# a_448_472# 0.02046f
C70 VSS a_796_472# 0.05215f
C71 a_1000_472# RN 0.08402f
C72 a_1000_472# a_1456_156# 0
C73 a_1000_472# VSS 0.04416f
C74 a_1000_472# a_796_472# 0.04876f
C75 a_36_151# Q 0
C76 a_1204_472# VDD 0.2874f
C77 a_2560_156# a_448_472# 0.27749f
C78 a_1204_472# VNW 0.02924f
C79 a_36_151# RN 0.0801f
C80 a_36_151# VSS 0.29184f
C81 a_36_151# a_796_472# 0.01196f
C82 VDD D 0.00937f
C83 VNW D 0.12823f
C84 a_36_151# a_1000_472# 0.08771f
C85 a_448_472# RN 0.07955f
C86 a_448_472# a_1456_156# 0.00227f
C87 a_448_472# VSS 1.20207f
C88 a_448_472# a_796_472# 0.40299f
C89 a_1000_472# a_448_472# 0.36607f
C90 a_36_151# a_448_472# 0.53712f
C91 Q VPW 0.11476f
C92 VSS VPW 1.25728f
C93 RN VPW 1.14357f
C94 D VPW 0.14182f
C95 VDD VPW 0.77252f
C96 CLK VPW 0.17966f
C97 VNW VPW 6.1377f
C98 a_2560_156# VPW 0.01424f
C99 a_2665_112# VPW 0.37797f
C100 a_2248_156# VPW 0.2461f
C101 a_1000_472# VPW 0.16604f
C102 a_796_472# VPW 0.02049f
C103 a_1308_423# VPW 0.15961f
C104 a_448_472# VPW 0.44548f
C105 a_36_151# VPW 1.08135f
.ends
