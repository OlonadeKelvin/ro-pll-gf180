* NGSPICE file created from gf180mcu_fd_sc_mcu7t5v0__nand2_1.ext - technology: gf180mcuD

.subckt UN_NAND2_0_GF180mcuD VDD VNW VPW VSS A1 A2 ZN
X0 ZN A2 VDD VNW pfet_05v0 ad=0.2938p pd=1.65u as=0.4972p ps=3.14u w=1.13u l=0.5u
X1 ZN A1 a_245_68# VPW nfet_05v0 ad=0.3608p pd=2.52u as=0.1312p ps=1.14u w=0.82u l=0.6u
X2 VDD A1 ZN VNW pfet_05v0 ad=0.4972p pd=3.14u as=0.2938p ps=1.65u w=1.13u l=0.5u
X3 a_245_68# A2 VSS VPW nfet_05v0 ad=0.1312p pd=1.14u as=0.3608p ps=2.52u w=0.82u l=0.6u
C0 a_245_68# A1 0.00883f
C1 VNW VDD 0.11309f
C2 a_245_68# ZN 0
C3 A2 A1 0.2264f
C4 A2 ZN 0.04777f
C5 VSS A1 0.13214f
C6 a_245_68# A2 0
C7 VSS ZN 0.09851f
C8 VNW A1 0.11976f
C9 A1 VDD 0.03659f
C10 a_245_68# VSS 0.00268f
C11 VNW ZN 0.04177f
C12 VDD ZN 0.247f
C13 VSS A2 0.05455f
C14 a_245_68# VDD 0
C15 VNW A2 0.1254f
C16 A2 VDD 0.04881f
C17 VSS VNW 0.00617f
C18 VSS VDD 0.01771f
C19 A1 ZN 0.36366f
C20 VSS VPW 0.23525f
C21 ZN VPW 0.08833f
C22 VDD VPW 0.21424f
C23 A1 VPW 0.17937f
C24 A2 VPW 0.20324f
C25 VNW VPW 1.13753f
.ends
